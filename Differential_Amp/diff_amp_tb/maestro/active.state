ADE simulation setup
Test Differential_Amp_diff_amp_tb_1: Differential_Amp/diff_amp_tb/config, simulator spectre
  Models: /home/install/FOUNDRY/analog/180nm/models/spectre/gpdk.scs[stat]
  Temperature: 27
  Analysis tran: stop=400n
  Analysis dc: (saves the operating point)
  Output A(gain) = value(dB20(VF("/VOUT")) 0)
  Output BW = bandwidth(VF("/VOUT") 3 "low")
  Output GBW = (bandwidth(VF("/VOUT") 3 "low") * value(dB20(VF("/VOUT")) 0))
  Output O/P SWING = (ymax(v("/VOUT" ?result "tran")) - ymin(v("/VOUT" ?result "tran")))
  Signals: /VOUT
Run mode: Single Run, Sweeps and Corners
Corners:
  model folders: /home/install/FOUNDRY/analog/180nm/models/spectre
  C0 (off): temperature=-40,27,90; V=1.62,1.80,1.98; Lin1=300n,360n,420n; Lin2=300n,360n,420n; gpdk.scs[FF]
  C1 (off): temperature=-40,27,90; V=1.62,1.80,1.98; Lin1=300n,360n,420n; Lin2=300n,360n,420n; gpdk.scs[FS]
  C2 (off): temperature=-40,27,90; V=1.62,1.80,1.98; Lin1=300n,360n,420n; Lin2=300n,360n,420n; gpdk.scs[NN]
  C3 (off): temperature=-40,27,90; V=1.62,1.80,1.98; Lin1=300n,360n,420n; Lin2=300n,360n,420n; gpdk.scs[SF]
  C4 (off): temperature=-40,27,90; V=1.62,1.80,1.98; Lin1=300n,360n,420n; Lin2=300n,360n,420n; gpdk.scs[SS]

ADE simulation setup
Test Differential_Amp_diff_amp_tb_1: Differential_Amp/diff_amp_tb/config, simulator spectre
  Models: /home/install/FOUNDRY/analog/180nm/models/spectre/gpdk.scs[stat]
  Temperature: 27
  Analysis tran: stop=400n
  Analysis dc: (saves the operating point)
  Output A(gain) = value(dB20(VF("/VOUT")) 0)
  Output BW = bandwidth(VF("/VOUT") 3 "low")
  Output GBW = (bandwidth(VF("/VOUT") 3 "low") * value(dB20(VF("/VOUT")) 0))
  Output O/P SWING = (ymax(v("/VOUT" ?result "tran")) - ymin(v("/VOUT" ?result "tran")))
  Signals: /VOUT

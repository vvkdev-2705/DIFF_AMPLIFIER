ADE simulation setup
Test Differential_Amp_diff_amp_1: Differential_Amp/diff_amp/schematic, simulator spectre
  Models: /home/install/FOUNDRY/analog/180nm/models/spectre/gpdk.scs[stat]
  Variables: V = 1.8
  Temperature: 27
  Operating points saved: /M3 (pwr region); /M1 (pwr ids region); /M2 (pwr ids region); /M4 (pwr region); /M5 (pwr ids region); /M6 (pwr ids region)
  Analysis tran: stop=400n
  Analysis ac: start=1 stop=1G dec=100
  Analysis dc: (saves the operating point)
  Output OS("/M3" "region")
  Output OS("/M1" "region")
  Output OS("/M2" "region")
  Output OS("/M4" "region")
  Output OS("/M5" "region")
  Output OS("/M6" "region")
  Output OS("/M5" "ids")
  Output OS("/M6" "ids")
  Output OS("/M1" "ids")
  Output OS("/M2" "ids")
  Output A(gain) = value(dB20(VF("/VOUT")) 0)
  Output BW = bandwidth(VF("/VOUT") 3 "low")
  Output GBW = (bandwidth(VF("/VOUT") 3 "low") * value(dB20(VF("/VOUT")) 0))
  Output POWER = (OS("/M1" "pwr") + OS("/M2" "pwr") + OS("/M3" "pwr") + OS("/M4" "pwr") + OS("/M5" "pwr") + OS("/M6" "pwr"))
  Output O/P SWING = (ymax(v("/VOUT" ?result "tran")) - ymin(v("/VOUT" ?result "tran")))
  Signals: /VOUT

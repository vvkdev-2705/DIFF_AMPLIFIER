ADE simulation setup
Test Differential_Amp_diff_amp_1: Differential_Amp/diff_amp/schematic, simulator spectre
  Models: /home/install/FOUNDRY/analog/180nm/models/spectre/gpdk.scs[stat]
  Temperature: 27
  Operating points saved: /M3 (pwr region); /M1 (pwr ids region); /M2 (pwr ids region); /M4 (pwr region); /M5 (pwr ids region); /M6 (pwr ids region)
  Analysis ac: start=1 stop=1G dec=100
  Analysis dc: (saves the operating point)
  Analysis tran: stop=400n
  Output OS("/M3" "region") (unticked)
  Output OS("/M1" "region") (unticked)
  Output OS("/M2" "region") (unticked)
  Output OS("/M4" "region") (unticked)
  Output OS("/M5" "region") (unticked)
  Output OS("/M6" "region") (unticked)
  Output OS("/M5" "ids") (unticked)
  Output OS("/M6" "ids") (unticked)
  Output OS("/M1" "ids") (unticked)
  Output OS("/M2" "ids") (unticked)
  Output A(gain) = value(dB20(VF("/VOUT")) 0)
  Output BW = bandwidth(VF("/VOUT") 3 "low")
  Output GBW = (bandwidth(VF("/VOUT") 3 "low") * value(dB20(VF("/VOUT")) 0))
  Output POWER = (OS("/M1" "pwr") + OS("/M2" "pwr") + OS("/M3" "pwr") + OS("/M4" "pwr") + OS("/M5" "pwr") + OS("/M6" "pwr"))
  Output O/P SWING = (ymax(v("/VOUT" ?result "tran")) - ymin(v("/VOUT" ?result "tran")))
  Signals: /VOUT
Run mode: Single Run, Sweeps and Corners
Corners (all switched off):
  model folders: /home/install/FOUNDRY/analog/180nm/models/spectre
  C0 (off): temperature=-40,27,90; V=1.62,1.80,1.98; Lin1=300n,360n,420n; Lin2=300n,360n,420n; gpdk.scs[FF]
  C1 (off): temperature=-40,27,90; V=1.62,1.80,1.98; Lin1=300n,360n,420n; Lin2=300n,360n,420n; gpdk.scs[FS]
  C2 (off): temperature=-40,27,90; V=1.62,1.80,1.98; Lin1=300n,360n,420n; Lin2=300n,360n,420n; gpdk.scs[NN]
  C3 (off): temperature=-40,27,90; V=1.62,1.80,1.98; Lin1=300n,360n,420n; Lin2=300n,360n,420n; gpdk.scs[SF]
  C4 (off): temperature=-40,27,90; V=1.62,1.80,1.98; Lin1=300n,360n,420n; Lin2=300n,360n,420n; gpdk.scs[SS]
